* Circuito RC Simple
Vin in gnd DC 5
R1 in out 10k
C1 out gnd 10u IC=0

* Opcion necesaria para poder ver corrientes de resistencias y condensadores
.options savecurrents

* Bloque de control de ngspice para análisis
.control
    * 1. Análisis de punto de trabajo (Operating Point)
    op
    * Imprimir por pantalla los voltajes y corrientes en DC
    print all

    * 2. Análisis transitorio (paso, tiempo_final, tiempo_inicio, paso_subida, uic para usar el IC=0)
    * Vamos a simular hasta 100ms con pasos de 0.1ms, sin permitir que el paso de simulación sea menor
    * a 0.5ms, guardando desde el instante 0ms.
    tran 0.1m 500m 0m 0.5m uic
    * Guardar los datos en un archivo de texto
    wrdata datos_rc.txt V(in) V(out) @R1[i]
.endc
.end
