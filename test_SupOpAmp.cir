* Test for SupOpAmp.cir
.include SupOpAmp.cir

Vcc vcc 0 15
Vee vee 0 -15
Vin in 0 1m

Xtest in 0 out vcc vee 0 SupOpAmp

.op
.print op v(out)
.end
